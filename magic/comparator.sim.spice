* NGSPICE file created from comparator_pex.ext - technology: ihp-sg13g2

.subckt comparator_pex Vbias in_p in_n VGND VPWR out
X0 diff R1 VPWR VPWR sg13_lv_pmos ad=0.5p pd=2.5u as=0.5p ps=2.5u w=2u l=0.3u
X1 VPWR R1 R1 VPWR sg13_lv_pmos ad=0.5p pd=2.5u as=0.5p ps=2.5u w=2u l=0.3u
X2 VPWR diff a_3050_980# VPWR sg13_lv_pmos ad=0.5p pd=2.5u as=0.5p ps=2.5u w=2u l=0.3u
X3 VPWR R1 diff VPWR sg13_lv_pmos ad=0.5p pd=2.5u as=1.1p ps=5.1u w=2u l=0.3u
X4 R2 in_p R1 VGND.t0 sg13_lv_nmos ad=1p pd=4.5u as=2.2p ps=9.1u w=4u l=0.3u
X5 R1 R1 VPWR VPWR sg13_lv_pmos ad=1.1p pd=5.1u as=0.5p ps=2.5u w=2u l=0.3u
X6 VPWR diff a_3050_980# VPWR sg13_lv_pmos ad=1.1p pd=5.1u as=0.5p ps=2.5u w=2u l=0.3u
X7 VGND.t6 a_3050_980# out VGND.t5 sg13_lv_nmos ad=0.225p pd=1.9u as=0.225p ps=1.9u w=0.5u l=0.15u
X8 VPWR R1 R1 VPWR sg13_lv_pmos ad=0.5p pd=2.5u as=1.1p ps=5.1u w=2u l=0.3u
X9 R2 Vbias VGND.t2 VGND.t1 sg13_lv_nmos ad=1.1p pd=5.1u as=1.1p ps=5.1u w=2u l=0.45u
X10 R1 R1 VPWR VPWR sg13_lv_pmos ad=0.5p pd=2.5u as=0.5p ps=2.5u w=2u l=0.3u
X11 a_3050_980# diff VPWR VPWR sg13_lv_pmos ad=0.5p pd=2.5u as=0.5p ps=2.5u w=2u l=0.3u
X12 diff R1 VPWR VPWR sg13_lv_pmos ad=1.1p pd=5.1u as=0.5p ps=2.5u w=2u l=0.3u
X13 VPWR R1 diff VPWR sg13_lv_pmos ad=0.5p pd=2.5u as=0.5p ps=2.5u w=2u l=0.3u
X14 diff in_n R2 VGND.t0 sg13_lv_nmos ad=2.2p pd=9.1u as=1p ps=4.5u w=4u l=0.3u
X15 a_3050_980# diff VPWR VPWR sg13_lv_pmos ad=0.5p pd=2.5u as=1.1p ps=5.1u w=2u l=0.3u
X16 out a_3050_980# VPWR VPWR sg13_lv_pmos ad=0.6p pd=3.4u as=0.6p ps=3.4u w=1.2u l=0.15u
X17 VGND.t4 Vbias a_3050_980# VGND.t3 sg13_lv_nmos ad=2.22p pd=10.1u as=1.1p ps=5.1u w=2u l=0.45u
R0 VGND.n5 VGND.t0 6044.22
R1 VGND.t5 VGND.t3 478.993
R2 VGND.t3 VGND.t4 222.714
R3 VGND.t0 VGND.t1 88.2358
R4 VGND.n5 VGND.t5 44.1181
R5 VGND.n5 VGND.n4 26.0005
R6 VGND.n6 VGND.n5 26.0005
R7 VGND.n6 VGND.t6 9.5338
R8 VGND.n4 VGND.t6 9.5338
R9 VGND.n4 VGND.n2 4.85902
R10 VGND.n7 VGND.n6 4.85902
R11 VGND.n8 VGND.n7 2.97569
R12 VGND.n0 VGND.n2 2.97569
R13 VGND.n0 VGND.t2 2.92925
R14 VGND.t2 VGND.n8 2.92925
R15 VGND.t1 VGND.n1 2.46422
R16 VGND.n7 VGND.n3 1.67649
R17 VGND.n3 VGND.n2 1.67615
R18 VGND.n1 VGND.n0 1.35428
R19 VGND.n8 VGND.n1 1.35428
R20 VGND.t4 VGND.n3 1.25558
R21 VGND VGND.n0 0.0005
C0 VPWR in_p 0.04749f
C1 R1 Vbias 0.01373f
C2 R2 diff 0.16013f
C3 in_n R1 0.00547f
C4 Vbias in_p 0.2306f
C5 in_n in_p 0.0326f
C6 VPWR diff 1.87646f
C7 Vbias diff 0.00803f
C8 in_n diff 0.44828f
C9 Vbias R2 0.17395f
C10 in_n R2 0.1799f
C11 R1 in_p 0.45382f
C12 out VPWR 0.10919f
C13 VPWR Vbias 0.90891f
C14 in_n VPWR 0.04754f
C15 a_3050_980# diff 0.17165f
C16 out Vbias 0.04337f
C17 in_n Vbias 0.2306f
C18 R1 diff 0.37165f
C19 R1 R2 0.16823f
C20 VPWR a_3050_980# 1.62713f
C21 in_p R2 0.1799f
C22 out a_3050_980# 0.1659f
C23 Vbias a_3050_980# 0.32408f
C24 R1 VPWR 1.92409f
C25 out VGND 1.42305f
C26 VPWR VGND 2.1489f
C27 R2 VGND 4.93712f
C28 VGND.t6 VGND 0.71429f
C29 VGND.t2 VGND 3.28001f
.ends
