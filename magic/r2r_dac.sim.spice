* NGSPICE file created from r2r_dac_pex.ext - technology: ihp-sg13g2

.subckt r2r_dac_pex IN[0] IN[1] IN[2] IN[3] IN[4] IN[5] IN[6] IN[7] VGND OUT
X0 R0b.R1 R1c.R2 VGND.t29 rhigh l=14.3u w=2u
X1 VGND.t21 VGND.t22 VGND.t20 rhigh l=14.3u w=2u
X2 R4b.R1 IN[4] VGND.t19 rhigh l=14.3u w=2u
X3 OUT R7b.R2 VGND.t10 rhigh l=14.3u w=2u
X4 IN[7] R7b.R2 VGND.t26 rhigh l=14.3u w=2u
X5 OUT R7c.R2 VGND.t17 rhigh l=14.3u w=2u
X6 R0d.R1 VGND.t2 VGND.t4 rhigh l=14.3u w=2u
X7 R4c.R1 R5c.R2 VGND.t13 rhigh l=14.3u w=2u
X8 R6b.R1 IN[6] VGND.t25 rhigh l=14.3u w=2u
X9 VGND.t1 VGND.t2 VGND.t0 rhigh l=14.3u w=2u
X10 R6b.R1 R7c.R2 VGND.t23 rhigh l=14.3u w=2u
X11 R4c.R1 R3c.R2 VGND.t8 rhigh l=14.3u w=2u
X12 R6c.R1 R7c.R2 VGND.t11 rhigh l=14.3u w=2u
X13 IN[5] R5b.R2 VGND.t15 rhigh l=14.3u w=2u
X14 R2b.R1 R3c.R2 VGND.t6 rhigh l=14.3u w=2u
X15 R6c.R1 R5b.R2 VGND.t16 rhigh l=14.3u w=2u
X16 R6c.R1 R5c.R2 VGND.t28 rhigh l=14.3u w=2u
X17 R2c.R1 R1b.R2 VGND.t24 rhigh l=14.3u w=2u
X18 IN[1] R1b.R2 VGND.t7 rhigh l=14.3u w=2u
X19 R2c.R1 R1c.R2 VGND.t5 rhigh l=14.3u w=2u
X20 R4b.R1 R5c.R2 VGND.t9 rhigh l=14.3u w=2u
X21 R0b.R1 IN[0] VGND.t3 rhigh l=14.3u w=2u
X22 R4c.R1 R3b.R2 VGND.t14 rhigh l=14.3u w=2u
X23 IN[3] R3b.R2 VGND.t18 rhigh l=14.3u w=2u
X24 R0d.R1 R1c.R2 VGND.t27 rhigh l=14.3u w=2u
X25 R2b.R1 IN[2] VGND.t12 rhigh l=14.3u w=2u
X26 R2c.R1 R3c.R2 VGND.t30 rhigh l=14.3u w=2u
R0 VGND.t0 VGND.t4 457.767
R1 VGND.t4 VGND.t27 457.767
R2 VGND.t27 VGND.t29 457.767
R3 VGND.t29 VGND.t3 457.767
R4 VGND.t3 VGND.t5 457.767
R5 VGND.t5 VGND.t24 457.767
R6 VGND.t24 VGND.t7 457.767
R7 VGND.t7 VGND.t30 457.767
R8 VGND.t30 VGND.t6 457.767
R9 VGND.t6 VGND.t12 457.767
R10 VGND.t12 VGND.t8 457.767
R11 VGND.t8 VGND.t14 457.767
R12 VGND.t18 VGND.t13 457.767
R13 VGND.t13 VGND.t9 457.767
R14 VGND.t9 VGND.t19 457.767
R15 VGND.t19 VGND.t28 457.767
R16 VGND.t28 VGND.t16 457.767
R17 VGND.t16 VGND.t15 457.767
R18 VGND.t15 VGND.t11 457.767
R19 VGND.t11 VGND.t23 457.767
R20 VGND.t23 VGND.t25 457.767
R21 VGND.t25 VGND.t17 457.767
R22 VGND.t17 VGND.t10 457.767
R23 VGND.t10 VGND.t26 457.767
R24 VGND.t26 VGND.t20 457.767
R25 VGND.t14 VGND.t18 456.949
R26 VGND.t18 VGND.t0 268.483
R27 VGND.t18 VGND.t20 266.848
R28 VGND.n1 VGND.t18 0.397688
R29 VGND.t2 VGND.n0 4.02118
R30 VGND.t1 VGND.n0 4.18033
R31 VGND.n1 VGND.t22 4.15171
R32 VGND.n1 VGND.t21 4.21156
R33 VGND VGND.t2 2.61375
R34 VGND.t18 VGND.n0 1.05839
C0 a_5820_286# a_6380_286# 0.10745f
C1 IN[0] R2c.R1 0.0165f
C2 IN[2] a_6380_286# 0.13191f
C3 a_10300_286# R5b.R2 0.15477f
C4 R1c.R2 a_3580_286# 0.01158f
C5 R7c.R2 a_11980_286# 0.2645f
C6 a_10300_286# R6c.R1 0.26603f
C7 a_1340_286# R1c.R2 0.16634f
C8 IN[0] a_3020_286# 0.13191f
C9 IN[4] R5c.R2 0.29629f
C10 IN[3] R3c.R2 0.0068f
C11 IN[0] a_780_286# 0.02658f
C12 R7c.R2 a_13660_286# 0.01158f
C13 R4c.R1 a_7500_286# 0.22044f
C14 a_6940_286# a_7500_286# 0.10745f
C15 R6c.R1 R4b.R1 0.02498f
C16 a_9740_286# R5c.R2 0.26426f
C17 a_11420_286# R6c.R1 0.26566f
C18 IN[6] a_12540_286# 0.48535f
C19 a_4700_286# a_4140_286# 0.10745f
C20 R4c.R1 a_6380_286# 0.16783f
C21 a_6940_286# a_6380_286# 0.10745f
C22 IN[1] R1c.R2 0.0068f
C23 IN[4] a_9180_286# 0.48535f
C24 a_10860_286# IN[5] 0.48659f
C25 IN[0] R0b.R1 0.22805f
C26 R6b.R1 OUT 0.02801f
C27 R3b.R2 a_6940_286# 0.15477f
C28 a_3020_286# a_2460_286# 0.10745f
C29 a_9180_286# a_9740_286# 0.10745f
C30 IN[4] IN[5] 0.05222f
C31 IN[7] R7b.R2 0.1677f
C32 R2c.R1 a_3580_286# 0.26603f
C33 a_11980_286# a_11420_286# 0.10745f
C34 a_6380_286# R3c.R2 0.26426f
C35 IN[5] a_9740_286# 0.06026f
C36 IN[3] a_8060_286# 0.13191f
C37 a_12540_286# a_13100_286# 0.10745f
C38 a_3020_286# a_3580_286# 0.10745f
C39 IN[6] a_13100_286# 0.13191f
C40 R3b.R2 R3c.R2 0.02498f
C41 R1b.R2 R3c.R2 0.02498f
C42 a_1340_286# a_780_286# 0.10745f
C43 a_9180_286# R5c.R2 0.2193f
C44 a_10860_286# a_10300_286# 0.10745f
C45 IN[1] IN[2] 0.05222f
C46 R7c.R2 a_12540_286# 0.2193f
C47 IN[6] IN[5] 0.05222f
C48 a_2460_286# R0b.R1 0.15626f
C49 IN[4] a_10300_286# 0.06026f
C50 IN[6] R7c.R2 0.29629f
C51 a_8060_286# a_7500_286# 0.10745f
C52 IN[5] R5c.R2 0.0068f
C53 IN[1] R2c.R1 0.29416f
C54 R6b.R1 R6c.R1 0.02498f
C55 R1c.R2 a_1900_286# 0.2645f
C56 a_10300_286# a_9740_286# 0.10745f
C57 IN[1] a_3020_286# 0.06026f
C58 a_10860_286# a_11420_286# 0.10745f
C59 a_220_286# a_780_286# 0.10745f
C60 IN[4] R4b.R1 0.22805f
C61 IN[7] a_14780_286# 0.13922f
C62 R7b.R2 a_13660_286# 0.15477f
C63 IN[3] a_7500_286# 0.48659f
C64 IN[7] OUT 0.06611f
C65 IN[1] a_4700_286# 0.13191f
C66 R6b.R1 a_11980_286# 0.15626f
C67 R7c.R2 a_13100_286# 0.26426f
C68 IN[4] R4c.R1 0.0068f
C69 a_10300_286# R5c.R2 0.01158f
C70 IN[4] a_8620_286# 0.13191f
C71 IN[1] R3c.R2 0.0165f
C72 IN[3] a_6380_286# 0.06026f
C73 R7c.R2 IN[5] 0.0165f
C74 IN[6] a_11420_286# 0.06026f
C75 R2b.R1 a_5820_286# 0.15626f
C76 R2b.R1 IN[2] 0.22805f
C77 IN[3] R3b.R2 0.1677f
C78 R2b.R1 R2c.R1 0.02498f
C79 a_10300_286# IN[5] 0.13191f
C80 a_8620_286# R5c.R2 0.2645f
C81 R0d.R1 a_780_286# 0.15626f
C82 a_9180_286# R4b.R1 0.15626f
C83 R3b.R2 a_7500_286# 0.15477f
C84 a_4140_286# R1b.R2 0.15477f
C85 R2b.R1 R4c.R1 0.02498f
C86 a_13660_286# OUT 0.21157f
C87 IN[5] a_11420_286# 0.13191f
C88 IN[0] a_2460_286# 0.4881f
C89 R1c.R2 a_3020_286# 0.26426f
C90 a_1900_286# R0b.R1 0.15626f
C91 R7c.R2 a_11420_286# 0.16634f
C92 IN[1] a_5260_286# 0.06026f
C93 a_9180_286# a_8620_286# 0.10745f
C94 a_14220_286# R7b.R2 0.15477f
C95 IN[4] a_8060_286# 0.06026f
C96 R6b.R1 a_12540_286# 0.15626f
C97 a_4140_286# a_3580_286# 0.10745f
C98 R0b.R1 R0d.R1 0.02498f
C99 IN[0] a_3580_286# 0.06026f
C100 IN[2] a_5820_286# 0.48535f
C101 IN[6] R6b.R1 0.22805f
C102 IN[7] a_13660_286# 0.13922f
C103 IN[0] a_1340_286# 0.06361f
C104 a_11980_286# R6c.R1 0.01159f
C105 IN[2] R2c.R1 0.0068f
C106 IN[4] IN[3] 0.05222f
C107 a_8060_286# R5c.R2 0.16634f
C108 R1b.R2 a_3580_286# 0.15477f
C109 IN[1] a_4140_286# 0.48659f
C110 IN[1] IN[0] 0.05222f
C111 R7c.R2 R7b.R2 0.02498f
C112 IN[2] a_6940_286# 0.06026f
C113 IN[2] R4c.R1 0.0165f
C114 a_3020_286# R2c.R1 0.16783f
C115 a_14220_286# a_14780_286# 0.10745f
C116 IN[2] a_4700_286# 0.06026f
C117 IN[6] OUT 0.03924f
C118 R4c.R1 R4b.R1 0.02498f
C119 a_8620_286# R4b.R1 0.15626f
C120 IN[3] R5c.R2 0.0165f
C121 R2b.R1 a_5260_286# 0.15626f
C122 a_5820_286# R3c.R2 0.2193f
C123 a_10860_286# R5b.R2 0.15477f
C124 IN[2] R3c.R2 0.29629f
C125 a_10860_286# R6c.R1 0.22044f
C126 a_4700_286# R2c.R1 0.26566f
C127 IN[1] R1b.R2 0.1677f
C128 R4c.R1 a_6940_286# 0.26603f
C129 IN[4] R6c.R1 0.0165f
C130 R2c.R1 R0b.R1 0.02498f
C131 R4c.R1 a_8620_286# 0.01159f
C132 IN[6] IN[7] 0.04447f
C133 R6c.R1 a_9740_286# 0.16783f
C134 IN[7] a_14220_286# 0.57196f
C135 a_13100_286# OUT 0.21157f
C136 IN[1] a_3580_286# 0.13191f
C137 a_6940_286# R3c.R2 0.01158f
C138 IN[0] a_1900_286# 0.13191f
C139 IN[6] R6c.R1 0.0068f
C140 a_4700_286# R3c.R2 0.16634f
C141 R5b.R2 R5c.R2 0.02498f
C142 IN[7] a_13100_286# 0.06026f
C143 R3b.R2 R5c.R2 0.02498f
C144 a_5820_286# a_5260_286# 0.10745f
C145 IN[2] a_5260_286# 0.13191f
C146 a_11980_286# a_12540_286# 0.10745f
C147 IN[0] R1c.R2 0.34488f
C148 IN[6] a_11980_286# 0.13191f
C149 IN[7] R7c.R2 0.0068f
C150 R2c.R1 a_5260_286# 0.01159f
C151 a_2460_286# a_1900_286# 0.10745f
C152 IN[3] IN[2] 0.05222f
C153 R4c.R1 a_8060_286# 0.26566f
C154 IN[6] a_13660_286# 0.06361f
C155 IN[5] R5b.R2 0.1677f
C156 IN[5] R6c.R1 0.29416f
C157 a_8620_286# a_8060_286# 0.10745f
C158 a_14220_286# a_13660_286# 0.10745f
C159 R7c.R2 R5b.R2 0.02498f
C160 a_1340_286# a_1900_286# 0.10745f
C161 R1c.R2 R1b.R2 0.02498f
C162 IN[4] a_9740_286# 0.13191f
C163 a_1340_286# R0d.R1 0.15626f
C164 a_4700_286# a_5260_286# 0.10745f
C165 R1c.R2 a_2460_286# 0.21701f
C166 IN[3] a_6940_286# 0.13191f
C167 IN[3] R4c.R1 0.29416f
C168 IN[3] a_8620_286# 0.06026f
C169 a_5260_286# R3c.R2 0.2645f
C170 IN[5] a_11980_286# 0.06026f
C171 a_4140_286# R2c.R1 0.22044f
C172 a_13660_286# a_13100_286# 0.10745f
C173 IN[7] VGND 2.90787f
C174 OUT VGND 4.5559f
C175 IN[6] VGND 2.51102f
C176 IN[5] VGND 2.5353f
C177 IN[4] VGND 2.53522f
C178 IN[3] VGND 2.5353f
C179 IN[2] VGND 2.53522f
C180 IN[1] VGND 2.5353f
C181 IN[0] VGND 2.72084f
C182 R7b.R2 VGND 4.16048f
C183 R6b.R1 VGND 4.10265f
C184 R7c.R2 VGND 6.31496f
C185 R5b.R2 VGND 4.10346f
C186 R6c.R1 VGND 6.31345f
C187 R4b.R1 VGND 4.10265f
C188 R5c.R2 VGND 6.31496f
C189 R3b.R2 VGND 4.10346f
C190 R4c.R1 VGND 6.31345f
C191 R2b.R1 VGND 4.10265f
C192 R3c.R2 VGND 6.31496f
C193 R1b.R2 VGND 4.10346f
C194 R2c.R1 VGND 6.31345f
C195 R0b.R1 VGND 4.10259f
C196 R1c.R2 VGND 6.33938f
C197 R0d.R1 VGND 4.24005f
C198 VGND.t2 VGND 3.79434f
C199 VGND.t21 VGND 2.06777f
C200 VGND.t1 VGND 2.06591f
C201 VGND.t22 VGND 2.06777f
.ends
