* NGSPICE file created from tt_um_algofoogle_analog_junk.ext - technology: ihp-sg13g2

.subckt sg13_lv_pmos_P4FHLC B D S G
X0 S G D B sg13_lv_pmos ad=0.2236p pd=2.24u as=0.2236p ps=2.24u w=1u l=0.3u
**devattr s=13600,536 d=13600,536
.ends

.subckt sg13_lv_nmos_WZWL4E B D S G
X0 S G D B sg13_lv_nmos ad=0.558p pd=4.32u as=0.558p ps=4.32u w=2u l=0.45u
**devattr s=27200,936 d=27200,936
.ends

.subckt vbias Vbias VPWR sub
Xsg13_lv_pmos_P4FHLC_0 VPWR VPWR Vbias Vbias sg13_lv_pmos_P4FHLC
Xsg13_lv_nmos_WZWL4E_0 sub sub Vbias Vbias sg13_lv_nmos_WZWL4E
.ends

.subckt comparator Vbias in_p in_n VGND VPWR out
X0 diff R1 VPWR VPWR sg13_lv_pmos ad=1.08604p pd=5.75167u as=1.24087p ps=5.4127u w=2u l=0.3u
**devattr s=20000,500 d=20000,500
X1 VPWR R1 R1 VPWR sg13_lv_pmos ad=1.24087p pd=5.4127u as=1.19354p ps=4.66833u w=2u l=0.3u
**devattr s=20000,500 d=20000,500
X2 VPWR diff a_3050_980# VPWR sg13_lv_pmos ad=1.24087p pd=5.4127u as=1.816p ps=8.48u w=2u l=0.3u
**devattr s=20000,500 d=20000,500
X3 VPWR R1 diff VPWR sg13_lv_pmos ad=1.24087p pd=5.4127u as=1.08604p ps=5.75167u w=2u l=0.3u
**devattr s=44000,1020 d=20000,500
X4 R2 in_p R1 VGND sg13_lv_nmos ad=1.064p pd=5.64u as=2.38708p ps=9.33667u w=4u l=0.3u
**devattr s=88000,1820 d=40000,900
X5 R1 R1 VPWR VPWR sg13_lv_pmos ad=1.19354p pd=4.66833u as=1.24087p ps=5.4127u w=2u l=0.3u
**devattr s=20000,500 d=44000,1020
X6 VPWR diff a_3050_980# VPWR sg13_lv_pmos ad=1.24087p pd=5.4127u as=1.816p ps=8.48u w=2u l=0.3u
**devattr s=20000,500 d=44000,1020
X7 VGND a_3050_980# out VGND sg13_lv_nmos ad=3.96389p pd=17.38889u as=0.22794p ps=1.20588u w=0.5u l=0.15u
**devattr s=9000,380 d=9000,380
X8 VPWR R1 R1 VPWR sg13_lv_pmos ad=1.24087p pd=5.4127u as=1.19354p ps=4.66833u w=2u l=0.3u
**devattr s=44000,1020 d=20000,500
X9 R2 Vbias VGND VGND sg13_lv_nmos ad=0.532p pd=2.82u as=15.85555p ps=69.55556u w=2u l=0.45u
**devattr s=44000,1020 d=44000,1020
X10 R1 R1 VPWR VPWR sg13_lv_pmos ad=1.19354p pd=4.66833u as=1.24087p ps=5.4127u w=2u l=0.3u
**devattr s=20000,500 d=20000,500
X11 a_3050_980# diff VPWR VPWR sg13_lv_pmos ad=1.816p pd=8.48u as=1.24087p ps=5.4127u w=2u l=0.3u
**devattr s=20000,500 d=20000,500
X12 diff R1 VPWR VPWR sg13_lv_pmos ad=1.08604p pd=5.75167u as=1.24087p ps=5.4127u w=2u l=0.3u
**devattr s=20000,500 d=44000,1020
X13 VPWR R1 diff VPWR sg13_lv_pmos ad=1.24087p pd=5.4127u as=1.08604p ps=5.75167u w=2u l=0.3u
**devattr s=20000,500 d=20000,500
X14 diff in_n R2 VGND sg13_lv_nmos ad=2.17208p pd=11.50333u as=1.064p ps=5.64u w=4u l=0.3u
**devattr s=40000,900 d=88000,1820
X15 a_3050_980# diff VPWR VPWR sg13_lv_pmos ad=1.816p pd=8.48u as=1.24087p ps=5.4127u w=2u l=0.3u
**devattr s=44000,1020 d=20000,500
X16 out a_3050_980# VPWR VPWR sg13_lv_pmos ad=0.54706p pd=2.89412u as=0.74452p ps=3.24762u w=1.2u l=0.15u
**devattr s=24000,680 d=24000,680
X17 VGND Vbias a_3050_980# VGND sg13_lv_nmos ad=15.85555p pd=69.55556u as=1.816p ps=8.48u w=2u l=0.45u
**devattr s=44000,1020 d=44000,1020
.ends

.subckt rhigh10k R1 R2 sub
X0 R1 R2 sub rhigh l=14.3u w=2u
.ends

.subckt r2r_dac IN[0] IN[1] IN[2] IN[3] IN[4] IN[5] IN[6] IN[7] VGND OUT
XRdummy1 VGND VGND VGND rhigh10k
XRdummy2 VGND VGND VGND rhigh10k
XR7a IN[7] R7b/R2 VGND rhigh10k
XR6a R6b/R1 IN[6] VGND rhigh10k
XR7b OUT R7b/R2 VGND rhigh10k
XR5a IN[5] R5b/R2 VGND rhigh10k
XR6b R6b/R1 R7c/R2 VGND rhigh10k
XR7c OUT R7c/R2 VGND rhigh10k
XR3a IN[3] R3b/R2 VGND rhigh10k
XR4a R4b/R1 IN[4] VGND rhigh10k
XR4b R4b/R1 R5c/R2 VGND rhigh10k
XR5b R6c/R1 R5b/R2 VGND rhigh10k
XR5c R6c/R1 R5c/R2 VGND rhigh10k
XR6c R6c/R1 R7c/R2 VGND rhigh10k
XR2a R2b/R1 IN[2] VGND rhigh10k
XR3b R4c/R1 R3b/R2 VGND rhigh10k
XR4c R4c/R1 R5c/R2 VGND rhigh10k
XR1a IN[1] R1b/R2 VGND rhigh10k
XR2b R2b/R1 R3c/R2 VGND rhigh10k
XR3c R4c/R1 R3c/R2 VGND rhigh10k
XR0a R0b/R1 IN[0] VGND rhigh10k
XR1b R2c/R1 R1b/R2 VGND rhigh10k
XR2c R2c/R1 R3c/R2 VGND rhigh10k
XR0b R0b/R1 R1c/R2 VGND rhigh10k
XR1c R2c/R1 R1c/R2 VGND rhigh10k
XR0c R0d/R1 R1c/R2 VGND rhigh10k
XR0d R0d/R1 VGND VGND rhigh10k
.ends

.subckt tt_um_algofoogle_analog_junk clk ena rst_n ui_in[0] ui_in[1] ui_in[2] ui_in[3]
+ ui_in[4] ui_in[5] ui_in[6] ui_in[7] uio_in[0] uio_in[1] uio_in[2] uio_in[3] uio_in[4]
+ uio_in[5] uio_in[6] uio_in[7] uio_oe[0] uio_oe[1] uio_oe[2] uio_oe[3] uio_oe[4]
+ uio_oe[5] uio_oe[6] uio_oe[7] uio_out[0] uio_out[1] uio_out[2] uio_out[3] uio_out[4]
+ uio_out[5] uio_out[6] uio_out[7] uo_out[0] uo_out[1] uo_out[2] uo_out[3] uo_out[4]
+ uo_out[5] uo_out[6] uo_out[7] VDPWR VGND
Xvbias vbias/Vbias VDPWR VGND vbias
Xcomparator vbias/Vbias pdac/OUT ndac/OUT VGND VDPWR uo_out[7] comparator
Xpdac ui_in[0] ui_in[1] ui_in[2] ui_in[3] ui_in[4] ui_in[5] ui_in[6] ui_in[7] VGND
+ pdac/OUT r2r_dac
Xndac uio_in[0] uio_in[1] uio_in[2] uio_in[3] uio_in[4] uio_in[5] uio_in[6] uio_in[7]
+ VGND ndac/OUT r2r_dac
R0 VGND uio_oe[0] 0.000000
R1 VGND uio_oe[1] 0.000000
R2 VGND uio_oe[2] 0.000000
R3 VGND uio_oe[3] 0.000000
R4 VGND uio_oe[4] 0.000000
R5 VGND uio_oe[5] 0.000000
R6 VGND uio_oe[6] 0.000000
R7 VGND uio_oe[7] 0.000000
R10 VGND uio_out[0] 0.000000
R11 VGND uio_out[1] 0.000000
R12 VGND uio_out[2] 0.000000
R13 VGND uio_out[3] 0.000000
R14 VGND uio_out[4] 0.000000
R15 VGND uio_out[5] 0.000000
R16 VGND uio_out[6] 0.000000
R17 VGND uio_out[7] 0.000000
R20 VGND uo_out[0] 0.000000
R21 VGND uo_out[1] 0.000000
R22 VGND uo_out[2] 0.000000
R23 VGND uo_out[3] 0.000000
R24 VGND uo_out[4] 0.000000
R25 VGND uo_out[5] 0.000000
R26 VGND uo_out[6] 0.000000
* R27 VGND uo_out[7] 0.000000
.ends
