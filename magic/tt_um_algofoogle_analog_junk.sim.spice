* NGSPICE file created from tt_um_algofoogle_analog_junk_pex.ext - technology: ihp-sg13g2

.subckt tt_um_algofoogle_analog_junk_pex clk ena rst_n ui_in[0] ui_in[1] ui_in[2]
+ ui_in[3] ui_in[4] ui_in[5] ui_in[6] ui_in[7] uio_in[0] uio_in[1] uio_in[2] uio_in[3]
+ uio_in[4] uio_in[5] uio_in[6] uio_in[7] uio_oe[0] uio_oe[1] uio_oe[2] uio_oe[3]
+ uio_oe[4] uio_oe[5] uio_oe[6] uio_oe[7] uio_out[0] uio_out[1] uio_out[2] uio_out[3]
+ uio_out[4] uio_out[5] uio_out[6] uio_out[7] uo_out[0] uo_out[1] uo_out[2] uo_out[3]
+ uo_out[4] uo_out[5] uo_out[6] uo_out[7] VDPWR VGND
X0 VGND.t40 vbias.Vbias a_17980_29070# VGND.t17 sg13_lv_nmos ad=1.1p pd=5.1u as=1.1p ps=5.1u w=2u l=0.45u
X1 a_17980_29070# comparator.diff VDPWR VDPWR sg13_lv_pmos ad=0.5p pd=2.5u as=0.5p ps=2.5u w=2u l=0.3u
X2 VDPWR comparator.R1 comparator.diff VDPWR sg13_lv_pmos ad=0.5p pd=2.5u as=1.1p ps=5.1u w=2u l=0.3u
X3 ndac.OUT ndac.R7b.R2 VGND.t38 rhigh l=14.3u w=2u
X4 ndac.R0b.R1 uio_in[0] VGND.t60 rhigh l=14.3u w=2u
X5 comparator.R1 pdac.OUT comparator.R2 VGND.t28 sg13_lv_nmos ad=2.2p pd=9.1u as=1p ps=4.5u w=4u l=0.3u
X6 pdac.R4c.R1 pdac.R3b.R2 VGND.t16 rhigh l=14.3u w=2u
X7 uio_in[3] ndac.R3b.R2 VGND.t5 rhigh l=14.3u w=2u
X8 comparator.R1 comparator.R1 VDPWR VDPWR sg13_lv_pmos ad=1.1p pd=5.1u as=0.5p ps=2.5u w=2u l=0.3u
X9 pdac.R6c.R1 pdac.R5b.R2 VGND.t32 rhigh l=14.3u w=2u
X10 ui_in[5] pdac.R5b.R2 VGND.t51 rhigh l=14.3u w=2u
X11 ndac.R4c.R1 ndac.R3b.R2 VGND.t9 rhigh l=14.3u w=2u
X12 ui_in[1] pdac.R1b.R2 VGND.t2 rhigh l=14.3u w=2u
X13 ndac.R2c.R1 ndac.R3c.R2 VGND.t56 rhigh l=14.3u w=2u
X14 uio_in[5] ndac.R5b.R2 VGND.t8 rhigh l=14.3u w=2u
X15 VDPWR comparator.R1 comparator.R1 VDPWR sg13_lv_pmos ad=0.5p pd=2.5u as=0.5p ps=2.5u w=2u l=0.3u
X16 pdac.R4b.R1 pdac.R5c.R2 VGND.t31 rhigh l=14.3u w=2u
X17 pdac.R6b.R1 ui_in[6] VGND.t21 rhigh l=14.3u w=2u
X18 pdac.R0d.R1 pdac.R1c.R2 VGND.t3 rhigh l=14.3u w=2u
X19 uio_in[1] ndac.R1b.R2 VGND.t55 rhigh l=14.3u w=2u
X20 comparator.diff comparator.R1 VDPWR VDPWR sg13_lv_pmos ad=1.1p pd=5.1u as=0.5p ps=2.5u w=2u l=0.3u
X21 ndac.R4c.R1 ndac.R5c.R2 VGND.t69 rhigh l=14.3u w=2u
X22 pdac.R4c.R1 pdac.R3c.R2 VGND.t1 rhigh l=14.3u w=2u
X23 VGND.t18 a_17980_29070# uo_out[7] VGND.t17 sg13_lv_nmos ad=0.225p pd=1.9u as=0.225p ps=1.9u w=0.5u l=0.15u
X24 ndac.OUT ndac.R7c.R2 VGND.t47 rhigh l=14.3u w=2u
X25 ndac.R6b.R1 uio_in[6] VGND.t24 rhigh l=14.3u w=2u
X26 ndac.R0b.R1 ndac.R1c.R2 VGND.t57 rhigh l=14.3u w=2u
X27 ndac.R0d.R1 ndac.R1c.R2 VGND.t59 rhigh l=14.3u w=2u
X28 VDPWR comparator.R1 comparator.diff VDPWR sg13_lv_pmos ad=0.5p pd=2.5u as=0.5p ps=2.5u w=2u l=0.3u
X29 pdac.R2b.R1 ui_in[2] VGND.t22 rhigh l=14.3u w=2u
X30 ndac.R4c.R1 ndac.R3c.R2 VGND.t54 rhigh l=14.3u w=2u
X31 pdac.R2c.R1 pdac.R1b.R2 VGND.t66 rhigh l=14.3u w=2u
X32 ndac.R6c.R1 ndac.R5c.R2 VGND.t53 rhigh l=14.3u w=2u
X33 VDPWR comparator.diff a_17980_29070# VDPWR sg13_lv_pmos ad=0.5p pd=2.5u as=0.5p ps=2.5u w=2u l=0.3u
X34 pdac.R6c.R1 pdac.R5c.R2 VGND.t12 rhigh l=14.3u w=2u
X35 ndac.R6c.R1 ndac.R5b.R2 VGND.t39 rhigh l=14.3u w=2u
X36 ndac.R2b.R1 uio_in[2] VGND.t15 rhigh l=14.3u w=2u
X37 comparator.R2 ndac.OUT comparator.diff VGND.t28 sg13_lv_nmos ad=1p pd=4.5u as=2.2p ps=9.1u w=4u l=0.3u
X38 VGND.t26 VGND.t27 VGND.t25 rhigh l=14.3u w=2u
X39 ui_in[7] pdac.R7b.R2 VGND.t19 rhigh l=14.3u w=2u
X40 pdac.R2c.R1 pdac.R1c.R2 VGND.t45 rhigh l=14.3u w=2u
X41 VGND.t36 VGND.t37 VGND.t35 rhigh l=14.3u w=2u
X42 ndac.R2c.R1 ndac.R1b.R2 VGND.t58 rhigh l=14.3u w=2u
X43 ui_in[3] pdac.R3b.R2 VGND.t13 rhigh l=14.3u w=2u
X44 comparator.R1 comparator.R1 VDPWR VDPWR sg13_lv_pmos ad=0.5p pd=2.5u as=0.5p ps=2.5u w=2u l=0.3u
X45 pdac.R4c.R1 pdac.R5c.R2 VGND.t33 rhigh l=14.3u w=2u
X46 comparator.R2 vbias.Vbias VGND.t42 VGND.t41 sg13_lv_nmos ad=1.1p pd=5.1u as=1.1p ps=5.1u w=2u l=0.45u
X47 vbias.Vbias vbias.Vbias VDPWR VDPWR sg13_lv_pmos ad=0.34p pd=2.68u as=0.34p ps=2.68u w=1u l=0.3u
X48 pdac.R6c.R1 pdac.R7c.R2 VGND.t20 rhigh l=14.3u w=2u
X49 VGND.t68 VGND.t7 VGND.t67 rhigh l=14.3u w=2u
X50 uio_in[7] ndac.R7b.R2 VGND.t48 rhigh l=14.3u w=2u
X51 ndac.R2c.R1 ndac.R1c.R2 VGND.t61 rhigh l=14.3u w=2u
X52 pdac.R6b.R1 pdac.R7c.R2 VGND.t30 rhigh l=14.3u w=2u
X53 pdac.R0d.R1 VGND.t7 VGND.t6 rhigh l=14.3u w=2u
X54 ndac.R0d.R1 VGND.t63 VGND.t62 rhigh l=14.3u w=2u
X55 VDPWR comparator.diff a_17980_29070# VDPWR sg13_lv_pmos ad=1.1p pd=5.1u as=0.5p ps=2.5u w=2u l=0.3u
X56 pdac.R2b.R1 pdac.R3c.R2 VGND.t46 rhigh l=14.3u w=2u
X57 ndac.R6c.R1 ndac.R7c.R2 VGND.t4 rhigh l=14.3u w=2u
X58 VGND.t63 VGND.t65 VGND.t64 rhigh l=14.3u w=2u
X59 VDPWR comparator.R1 comparator.R1 VDPWR sg13_lv_pmos ad=0.5p pd=2.5u as=1.1p ps=5.1u w=2u l=0.3u
X60 ndac.R6b.R1 ndac.R7c.R2 VGND.t52 rhigh l=14.3u w=2u
X61 comparator.diff comparator.R1 VDPWR VDPWR sg13_lv_pmos ad=0.5p pd=2.5u as=0.5p ps=2.5u w=2u l=0.3u
X62 pdac.R4b.R1 ui_in[4] VGND.t49 rhigh l=14.3u w=2u
X63 a_17980_29070# comparator.diff VDPWR VDPWR sg13_lv_pmos ad=0.5p pd=2.5u as=1.1p ps=5.1u w=2u l=0.3u
X64 pdac.R2c.R1 pdac.R3c.R2 VGND.t34 rhigh l=14.3u w=2u
X65 ndac.R2b.R1 ndac.R3c.R2 VGND.t11 rhigh l=14.3u w=2u
X66 uo_out[7] a_17980_29070# VDPWR VDPWR sg13_lv_pmos ad=0.6p pd=3.4u as=0.6p ps=3.4u w=1.2u l=0.15u
X67 pdac.OUT pdac.R7b.R2 VGND.t29 rhigh l=14.3u w=2u
X68 pdac.R0b.R1 ui_in[0] VGND.t23 rhigh l=14.3u w=2u
X69 ndac.R4b.R1 ndac.R5c.R2 VGND.t10 rhigh l=14.3u w=2u
X70 ndac.R4b.R1 uio_in[4] VGND.t14 rhigh l=14.3u w=2u
X71 vbias.Vbias vbias.Vbias VGND.t44 VGND.t43 sg13_lv_nmos ad=0.68p pd=4.68u as=0.68p ps=4.68u w=2u l=0.45u
X72 pdac.OUT pdac.R7c.R2 VGND.t50 rhigh l=14.3u w=2u
X73 pdac.R0b.R1 pdac.R1c.R2 VGND.t0 rhigh l=14.3u w=2u
R0 VGND.n8 VGND.n6 13711.2
R1 VGND.n20 VGND.n19 10780.5
R2 VGND.n9 VGND.n8 8474.86
R3 VGND.n14 VGND.n6 7775.2
R4 VGND.t5 VGND.n20 4804.01
R5 VGND.n20 VGND.n6 4351.15
R6 VGND.n13 VGND.t17 636.793
R7 VGND.t17 VGND.n12 636.793
R8 VGND.n14 VGND.n13 185.732
R9 VGND.n12 VGND.n9 185.732
R10 VGND.n21 VGND.t41 125.841
R11 VGND.t48 VGND.t35 69.739
R12 VGND.t38 VGND.t48 69.739
R13 VGND.t47 VGND.t38 69.739
R14 VGND.t24 VGND.t47 69.739
R15 VGND.t52 VGND.t24 69.739
R16 VGND.t4 VGND.t52 69.739
R17 VGND.t39 VGND.t8 69.739
R18 VGND.t53 VGND.t39 69.739
R19 VGND.t14 VGND.t53 69.739
R20 VGND.t10 VGND.t14 69.739
R21 VGND.t69 VGND.t10 69.739
R22 VGND.t5 VGND.t69 69.739
R23 VGND.t9 VGND.t54 69.739
R24 VGND.t54 VGND.t15 69.739
R25 VGND.t15 VGND.t11 69.739
R26 VGND.t11 VGND.t56 69.739
R27 VGND.t12 VGND.t32 69.739
R28 VGND.t49 VGND.t12 69.739
R29 VGND.t31 VGND.t49 69.739
R30 VGND.t33 VGND.t31 69.739
R31 VGND.t13 VGND.t33 69.739
R32 VGND.t1 VGND.t16 69.739
R33 VGND.t22 VGND.t1 69.739
R34 VGND.t46 VGND.t22 69.739
R35 VGND.t34 VGND.t46 69.739
R36 VGND.t2 VGND.t34 69.739
R37 VGND.t66 VGND.t2 69.739
R38 VGND.t45 VGND.t66 69.739
R39 VGND.t23 VGND.t45 69.739
R40 VGND.t0 VGND.t23 69.739
R41 VGND.t3 VGND.t0 69.739
R42 VGND.t6 VGND.t3 69.739
R43 VGND.t67 VGND.t6 69.739
R44 VGND.t5 VGND.t9 69.6144
R45 VGND.t16 VGND.t13 69.6144
R46 VGND.n8 VGND.t28 64.6035
R47 VGND.n19 VGND.t41 59.8928
R48 VGND.t56 VGND.t13 57.7838
R49 VGND.t13 VGND.t67 41.209
R50 VGND.t58 VGND.t25 41.0964
R51 VGND.t61 VGND.t19 41.0964
R52 VGND.t60 VGND.t29 41.0964
R53 VGND.t57 VGND.t50 41.0964
R54 VGND.t59 VGND.t21 41.0964
R55 VGND.t62 VGND.t30 41.0964
R56 VGND.t64 VGND.t20 41.0964
R57 VGND.t35 VGND.t5 40.5983
R58 VGND.n21 VGND.t5 30.7602
R59 VGND.t25 VGND.t55 28.6431
R60 VGND.t19 VGND.t58 28.6431
R61 VGND.t29 VGND.t61 28.6431
R62 VGND.t50 VGND.t60 28.6431
R63 VGND.t21 VGND.t57 28.6431
R64 VGND.t30 VGND.t59 28.6431
R65 VGND.t20 VGND.t62 28.6431
R66 VGND.t51 VGND.t64 28.6431
R67 VGND.n19 VGND.n18 28.2643
R68 VGND.t32 VGND.n21 26.7751
R69 VGND.n15 VGND.n14 26.0005
R70 VGND.n10 VGND.n9 26.0005
R71 VGND.t7 VGND.t13 4.23367
R72 VGND.t5 VGND.t63 3.96941
R73 VGND.t5 VGND.t51 12.2047
R74 VGND.t55 VGND.t13 11.9557
R75 VGND.n10 VGND.t18 9.5338
R76 VGND.n15 VGND.t18 9.5338
R77 VGND.n18 VGND.t28 9.42177
R78 VGND.n13 VGND.t40 8.5005
R79 VGND.n12 VGND.t40 8.5005
R80 VGND.n22 VGND.t7 5.71648
R81 VGND.t68 VGND.t13 4.25126
R82 VGND.t5 VGND.t65 4.24352
R83 VGND.n0 VGND.t27 4.13445
R84 VGND.n0 VGND.t26 4.23246
R85 VGND.t37 VGND.n1 4.23246
R86 VGND.t36 VGND.n1 4.13445
R87 VGND.n11 VGND.n10 4.85902
R88 VGND.n16 VGND.n15 4.85902
R89 VGND.t43 VGND.n3 1.52492
R90 VGND.n2 VGND.n3 0.282537
R91 VGND.n2 VGND.t44 3.26133
R92 VGND.n11 VGND.n7 2.97569
R93 VGND.n4 VGND.n16 2.97569
R94 VGND.t42 VGND.n7 2.92925
R95 VGND.n4 VGND.t42 2.92925
R96 VGND.t8 VGND.n2 2.6617
R97 VGND.n18 VGND.n17 2.45637
R98 VGND.t44 VGND.n5 1.85415
R99 VGND VGND.n22 1.75545
R100 VGND.n16 VGND.t40 1.43994
R101 VGND.n17 VGND.n7 1.39821
R102 VGND.n5 VGND.n4 0.818682
R103 VGND.n17 VGND.n5 0.758533
R104 VGND.t4 VGND.n3 24.6125
R105 VGND.n22 VGND.t63 4.12882
R106 VGND.t40 VGND.n11 1.77834
R107 VGND.t5 VGND.n1 1.38519
R108 VGND VGND.n5 1.1485
R109 VGND.n0 VGND.t13 1.01597
C0 uio_in[6] ndac.R7c.R2 0.29629f
C1 a_32308_21386# ui_in[2] 0.13191f
C2 uio_in[1] a_23118_16306# 0.13615f
C3 ui_in[0] pdac.R2c.R1 0.0165f
C4 a_26708_21386# a_27268_21386# 0.10745f
C5 a_24238_16306# uio_in[1] 0.13191f
C6 uio_in[3] uio_in[2] 2.88819f
C7 a_25028_21386# pdac.OUT 0.21157f
C8 ui_in[3] ui_in[2] 0.36621f
C9 uio_in[3] uio_in[5] 0.16182f
C10 pdac.R1b.R2 pdac.R1c.R2 0.02498f
C11 uio_in[2] a_20878_16306# 0.06628f
C12 uio_in[2] a_21438_16306# 0.14407f
C13 a_18638_16306# ndac.R4b.R1 0.15626f
C14 uio_in[0] uio_in[4] 0.16294f
C15 uio_in[6] a_15838_16306# 0.13191f
C16 uio_in[3] a_19198_16306# 0.06026f
C17 ndac.R3c.R2 ndac.R1b.R2 0.02498f
C18 ui_in[7] a_23908_21386# 0.13922f
C19 comparator.R1 pdac.OUT 0.45382f
C20 a_14718_16306# a_14158_16306# 0.10745f
C21 a_26478_16306# uio_in[0] 0.06361f
C22 a_33428_21386# ui_in[2] 0.14623f
C23 pdac.OUT comparator.R2 0.18194f
C24 a_18078_16306# ndac.R5c.R2 0.26426f
C25 ui_in[1] pdac.R2c.R1 0.29753f
C26 a_28388_21386# pdac.R6c.R1 0.26603f
C27 a_30068_21386# pdac.R5c.R2 0.2645f
C28 a_35108_21386# a_35668_21386# 0.10745f
C29 uio_in[1] ndac.R2b.R1 0.00671f
C30 pdac.R1b.R2 a_34548_21386# 0.15477f
C31 uio_in[3] ndac.R3c.R2 0.0068f
C32 pdac.R7c.R2 a_26148_21386# 0.2193f
C33 a_21438_16306# ndac.R3c.R2 0.26426f
C34 ndac.R3c.R2 a_20878_16306# 0.01158f
C35 m5_37456_9556# m5_36352_9988# 0.05845f
C36 uio_in[6] uio_in[4] 0.16123f
C37 pdac.R0b.R1 pdac.R2c.R1 0.02498f
C38 ndac.OUT pdac.OUT 0.03321f
C39 uio_in[7] a_14158_16306# 0.13922f
C40 a_17518_16306# a_18078_16306# 0.10745f
C41 uio_in[3] a_20318_16306# 0.48659f
C42 a_34548_21386# a_33988_21386# 0.10745f
C43 a_36228_21386# a_35668_21386# 0.10745f
C44 a_20318_16306# a_20878_16306# 0.10745f
C45 a_26708_21386# pdac.R6c.R1 0.01159f
C46 uio_in[0] a_25358_16306# 0.4881f
C47 a_13598_16306# uio_in[7] 0.57196f
C48 uio_in[3] uio_in[4] 2.92122f
C49 a_21998_16306# a_22558_16306# 0.10745f
C50 ui_in[7] pdac.OUT 0.30944f
C51 pdac.R1b.R2 pdac.R3c.R2 0.02498f
C52 ui_in[5] a_27828_21386# 0.48659f
C53 uio_in[6] uio_in[0] 0.16262f
C54 a_18638_16306# a_19198_16306# 0.10745f
C55 a_17980_29070# vbias.Vbias 0.32282f
C56 pdac.R5b.R2 a_28388_21386# 0.15477f
C57 a_33988_21386# pdac.R3c.R2 0.16634f
C58 clk ena 0.007f
C59 uio_in[5] VDPWR 0.00612f
C60 pdac.R2b.R1 a_32868_21386# 0.15626f
C61 a_30068_21386# pdac.R4b.R1 0.15626f
C62 pdac.R6b.R1 a_26708_21386# 0.15626f
C63 a_14718_16306# ndac.OUT 0.21157f
C64 uio_in[7] comparator.R1 0.01292f
C65 uio_in[3] uio_in[0] 0.1634f
C66 ui_in[5] pdac.R7c.R2 0.0165f
C67 ndac.R7c.R2 a_15278_16306# 0.2193f
C68 m5_15472_14500# m5_3520_5044# 0.06368f
C69 a_36788_21386# pdac.R1c.R2 0.2645f
C70 pdac.R1b.R2 ui_in[1] 0.1677f
C71 a_28948_21386# pdac.R6c.R1 0.16783f
C72 a_17518_16306# ndac.R6c.R1 0.26603f
C73 ui_in[3] a_31188_21386# 0.48659f
C74 m5_31264_12388# m5_31216_13780# 0.01952f
C75 m5_26080_10468# m5_3520_5044# 0.25745f
C76 ndac.R5c.R2 uio_in[5] 0.0068f
C77 a_24798_16306# uio_in[0] 0.13502f
C78 a_15278_16306# a_15838_16306# 0.10745f
C79 a_33988_21386# ui_in[1] 0.13191f
C80 a_27038_16306# ndac.R0d.R1 0.15626f
C81 uio_in[7] ndac.OUT 0.19553f
C82 a_18638_16306# uio_in[4] 0.48535f
C83 m5_3520_5044# m5_14800_14164# 0.05032f
C84 ndac.R7b.R2 a_14158_16306# 0.15477f
C85 uio_in[3] uio_in[6] 0.15933f
C86 a_19198_16306# ndac.R5c.R2 0.2645f
C87 uio_in[2] a_21998_16306# 0.48535f
C88 a_19758_16306# ndac.R4c.R1 0.26566f
C89 a_25028_21386# ui_in[6] 0.06361f
C90 a_22558_16306# ndac.R2c.R1 0.01159f
C91 pdac.R7c.R2 ui_in[6] 0.29629f
C92 pdac.R4c.R1 ui_in[2] 0.0165f
C93 a_29508_21386# a_28948_21386# 0.10745f
C94 a_17518_16306# uio_in[5] 0.1329f
C95 m5_31792_12388# m5_32128_11860# 0.08143f
C96 a_33428_21386# pdac.R2b.R1 0.15626f
C97 a_13598_16306# ndac.R7b.R2 0.15477f
C98 uio_in[0] pdac.R7b.R2 0.0068f
C99 a_24798_16306# a_25358_16306# 0.10745f
C100 a_17980_29070# uo_out[7] 0.1672f
C101 uio_in[3] a_20878_16306# 0.13191f
C102 uio_in[3] a_21438_16306# 0.06026f
C103 a_26478_16306# a_25918_16306# 0.10745f
C104 ui_in[4] a_28388_21386# 0.06026f
C105 a_21438_16306# a_20878_16306# 0.10745f
C106 uio_in[2] pdac.OUT 0.08507f
C107 pdac.OUT uio_in[5] 0.08625f
C108 a_23678_16306# ndac.R2c.R1 0.22044f
C109 a_33428_21386# pdac.R2c.R1 0.01159f
C110 a_16958_16306# a_17518_16306# 0.10745f
C111 a_26148_21386# a_26708_21386# 0.10745f
C112 a_25918_16306# uio_in[0] 0.13191f
C113 a_17980_29070# VDPWR 1.62706f
C114 a_36788_21386# ui_in[0] 0.13191f
C115 a_21998_16306# ndac.R3c.R2 0.2193f
C116 a_37908_21386# pdac.R0d.R1 0.15626f
C117 ndac.R1c.R2 a_24238_16306# 0.01158f
C118 pdac.OUT a_25588_21386# 0.21157f
C119 ndac.R5c.R2 uio_in[4] 0.29629f
C120 ui_in[3] a_30628_21386# 0.13191f
C121 ui_in[3] ui_in[4] 0.50735f
C122 ui_in[5] a_28388_21386# 0.13301f
C123 a_19198_16306# a_19758_16306# 0.10745f
C124 uio_in[7] a_13038_16306# 0.13922f
C125 ndac.R1c.R2 uio_in[1] 0.0068f
C126 a_37908_21386# ui_in[0] 0.02658f
C127 pdac.R1c.R2 ui_in[0] 0.34488f
C128 a_25918_16306# a_25358_16306# 0.10745f
C129 a_23908_21386# uio_in[0] 0.01263f
C130 uio_in[2] ndac.R2c.R1 0.0068f
C131 ui_in[7] ui_in[6] 0.92515f
C132 a_17518_16306# uio_in[4] 0.06026f
C133 ndac.R6c.R1 a_16398_16306# 0.26566f
C134 a_28388_21386# pdac.R5c.R2 0.01158f
C135 rst_n ui_in[0] 0.007f
C136 vbias.Vbias uo_out[7] 0.04388f
C137 a_14718_16306# ndac.R7c.R2 0.26426f
C138 uio_in[6] VDPWR 0.00864f
C139 a_26148_21386# a_25588_21386# 0.10745f
C140 uio_in[6] a_15278_16306# 0.48535f
C141 ui_in[5] a_26708_21386# 0.06026f
C142 m5_33808_12580# m5_35056_12388# 0.08512f
C143 a_36788_21386# pdac.R0b.R1 0.15626f
C144 a_35108_21386# pdac.R2c.R1 0.26603f
C145 ui_in[7] uio_in[1] 0.00523f
C146 pdac.OUT uio_in[4] 0.08584f
C147 a_19758_16306# a_20318_16306# 0.10745f
C148 a_23118_16306# a_22558_16306# 0.10745f
C149 pdac.R1c.R2 ui_in[1] 0.0068f
C150 vbias.Vbias VDPWR 1.52246f
C151 a_16398_16306# uio_in[5] 0.13191f
C152 uio_in[2] uio_in[7] 0.15883f
C153 ui_in[4] a_28948_21386# 0.13191f
C154 uio_in[7] uio_in[5] 0.16125f
C155 pdac.R3c.R2 a_31748_21386# 0.01158f
C156 comparator.R1 comparator.diff 0.37165f
C157 ui_in[3] pdac.R5c.R2 0.0165f
C158 a_19758_16306# uio_in[4] 0.0645f
C159 ndac.R7c.R2 a_16398_16306# 0.16634f
C160 uio_in[7] ndac.R7c.R2 0.0068f
C161 comparator.R2 comparator.diff 0.16013f
C162 uio_in[1] a_22558_16306# 0.06687f
C163 pdac.OUT uio_in[0] 0.18591f
C164 pdac.R4c.R1 a_31188_21386# 0.22044f
C165 a_23678_16306# a_23118_16306# 0.10745f
C166 a_33428_21386# a_33988_21386# 0.10745f
C167 a_13598_16306# a_14158_16306# 0.10745f
C168 a_24238_16306# a_23678_16306# 0.10745f
C169 a_24468_21386# pdac.R7b.R2 0.15477f
C170 pdac.R4c.R1 pdac.R2b.R1 0.02498f
C171 a_16958_16306# a_16398_16306# 0.10745f
C172 a_27268_21386# pdac.R6c.R1 0.26566f
C173 a_16398_16306# a_15838_16306# 0.10745f
C174 a_26708_21386# ui_in[6] 0.13267f
C175 uio_in[3] ndac.R5c.R2 0.0165f
C176 a_34548_21386# ui_in[1] 0.48659f
C177 ndac.OUT comparator.diff 0.44833f
C178 a_22558_16306# ndac.R2b.R1 0.15626f
C179 m5_30160_12388# m5_31264_12388# 0.04233f
C180 ui_in[5] a_28948_21386# 0.06324f
C181 a_31188_21386# pdac.R3b.R2 0.15477f
C182 a_23678_16306# uio_in[1] 0.48659f
C183 a_26478_16306# ndac.R0d.R1 0.15626f
C184 a_28948_21386# pdac.R5c.R2 0.26426f
C185 a_21438_16306# a_21998_16306# 0.10745f
C186 uio_in[6] pdac.OUT 0.08733f
C187 ndac.R4c.R1 ndac.R2b.R1 0.02498f
C188 uio_in[0] ndac.R2c.R1 0.02375f
C189 uio_in[2] a_23118_16306# 0.06026f
C190 pdac.R1b.R2 a_35108_21386# 0.15477f
C191 pdac.R3c.R2 ui_in[1] 0.0165f
C192 ui_in[1] ui_in[0] 0.22303f
C193 a_25028_21386# pdac.R7c.R2 0.01158f
C194 uo_out[7] VDPWR 0.10992f
C195 uio_in[7] uio_in[4] 0.15977f
C196 pdac.R0d.R1 pdac.R0b.R1 0.02498f
C197 a_35668_21386# pdac.R2c.R1 0.16783f
C198 ndac.R5b.R2 uio_in[5] 0.1677f
C199 pdac.OUT vbias.Vbias 0.25725f
C200 m5_31264_12388# m5_31792_12388# 0.07887f
C201 uio_in[3] pdac.OUT 0.0856f
C202 ndac.R5b.R2 ndac.R7c.R2 0.02498f
C203 a_23908_21386# a_24468_21386# 0.10745f
C204 a_25588_21386# ui_in[6] 0.13191f
C205 uio_in[2] uio_in[1] 2.94203f
C206 uio_in[1] uio_in[5] 0.15885f
C207 pdac.R0b.R1 ui_in[0] 0.23097f
C208 pdac.R2b.R1 ui_in[2] 0.23545f
C209 ndac.OUT a_14158_16306# 0.21157f
C210 ndac.R3b.R2 ndac.R3c.R2 0.02498f
C211 pdac.R4c.R1 a_30628_21386# 0.26566f
C212 ndac.R7b.R2 ndac.R7c.R2 0.02498f
C213 a_18638_16306# ndac.R5c.R2 0.2193f
C214 uio_in[3] a_19758_16306# 0.13191f
C215 uio_in[7] uio_in[0] 0.16263f
C216 ui_in[4] pdac.R4c.R1 0.01315f
C217 a_16958_16306# ndac.R5b.R2 0.15477f
C218 uio_in[6] a_14718_16306# 0.13191f
C219 uio_in[2] ndac.R2b.R1 0.23084f
C220 ndac.R3b.R2 a_20318_16306# 0.15477f
C221 a_23118_16306# ndac.R3c.R2 0.16634f
C222 comparator.R1 comparator.R2 0.16823f
C223 ui_in[2] pdac.R2c.R1 0.01628f
C224 ndac.R0b.R1 uio_in[0] 0.23181f
C225 ndac.OUT ndac.R6b.R1 0.02801f
C226 pdac.R6b.R1 pdac.R6c.R1 0.02498f
C227 uio_in[1] ndac.R3c.R2 0.0165f
C228 ndac.OUT comparator.R1 0.00547f
C229 a_30068_21386# ui_in[3] 0.06026f
C230 uio_in[6] a_16398_16306# 0.06026f
C231 a_25028_21386# ui_in[7] 0.13922f
C232 uio_in[6] uio_in[7] 3.31166f
C233 ui_in[7] pdac.R7c.R2 0.0068f
C234 ndac.OUT comparator.R2 0.18328f
C235 ndac.R0b.R1 a_25358_16306# 0.15626f
C236 m5_31792_12388# m5_31216_13780# 0.01782f
C237 ndac.R7c.R2 m5_3520_5044# 0.00853f
C238 a_24798_16306# ndac.R2c.R1 0.16783f
C239 a_32868_21386# pdac.R3c.R2 0.2193f
C240 a_32308_21386# a_31748_21386# 0.10745f
C241 uio_in[7] vbias.Vbias 0.02519f
C242 uio_in[1] uio_in[4] 0.15931f
C243 a_28388_21386# a_27828_21386# 0.10745f
C244 m5_30928_9556# m5_30016_10564# 0.08391f
C245 uio_in[3] uio_in[7] 0.15904f
C246 ui_in[3] a_31748_21386# 0.13869f
C247 a_24238_16306# uio_in[0] 0.06148f
C248 pdac.OUT VDPWR 0.04749f
C249 a_13598_16306# a_13038_16306# 0.10745f
C250 pdac.R5c.R2 pdac.R3b.R2 0.02498f
C251 a_17518_16306# ndac.R5c.R2 0.01158f
C252 uio_in[1] uio_in[0] 3.15204f
C253 a_32308_21386# pdac.R3c.R2 0.26426f
C254 a_36228_21386# a_36788_21386# 0.10745f
C255 ui_in[3] pdac.R3c.R2 0.0068f
C256 ui_in[5] a_27268_21386# 0.13191f
C257 a_35108_21386# pdac.R1c.R2 0.01158f
C258 a_24238_16306# ndac.R1b.R2 0.15477f
C259 pdac.R6b.R1 pdac.OUT 0.02801f
C260 uio_in[3] ndac.R3b.R2 0.1677f
C261 pdac.R7c.R2 a_26708_21386# 0.2645f
C262 a_33988_21386# ui_in[2] 0.07109f
C263 ndac.R6b.R1 ndac.R6c.R1 0.02498f
C264 ndac.R3b.R2 a_20878_16306# 0.15477f
C265 pdac.R4c.R1 pdac.R4b.R1 0.02498f
C266 a_33428_21386# pdac.R3c.R2 0.2645f
C267 a_14718_16306# a_15278_16306# 0.10745f
C268 ndac.R7c.R2 a_14158_16306# 0.01158f
C269 uio_in[1] ndac.R1b.R2 0.1677f
C270 a_19758_16306# ndac.R5c.R2 0.16634f
C271 a_36228_21386# pdac.R1c.R2 0.21701f
C272 uio_in[6] uio_in[1] 0.15865f
C273 ui_in[4] pdac.R6c.R1 0.0165f
C274 m5_30928_9556# m5_32128_9988# 0.0789f
C275 m5_33808_9988# m5_35104_9892# 0.09784f
C276 a_34548_21386# a_35108_21386# 0.10745f
C277 a_17980_29070# comparator.diff 0.17167f
C278 pdac.R6b.R1 a_26148_21386# 0.15626f
C279 pdac.R2b.R1 pdac.R2c.R1 0.02498f
C280 uio_in[3] uio_in[1] 0.16072f
C281 uio_in[7] VDPWR 0.04638f
C282 a_27268_21386# ui_in[6] 0.06026f
C283 a_33428_21386# ui_in[1] 0.06026f
C284 a_25028_21386# a_25588_21386# 0.10745f
C285 a_24798_16306# a_24238_16306# 0.10745f
C286 a_29508_21386# ui_in[4] 0.48535f
C287 a_25918_16306# ndac.R0b.R1 0.15626f
C288 pdac.R7c.R2 a_25588_21386# 0.26426f
C289 ui_in[5] pdac.R6c.R1 0.30031f
C290 a_31188_21386# a_30628_21386# 0.10745f
C291 a_24798_16306# uio_in[1] 0.06026f
C292 a_35108_21386# ui_in[0] 0.06026f
C293 ndac.R6b.R1 a_15838_16306# 0.15626f
C294 uio_in[6] m5_3520_5044# 0.0088f
C295 a_30068_21386# pdac.R4c.R1 0.01159f
C296 a_18078_16306# ndac.R6c.R1 0.16783f
C297 a_35668_21386# pdac.R1c.R2 0.26426f
C298 a_36228_21386# ui_in[0] 0.4881f
C299 ndac.R4b.R1 ndac.R4c.R1 0.02498f
C300 a_32308_21386# a_32868_21386# 0.10745f
C301 vbias.Vbias comparator.diff 0.00805f
C302 a_35108_21386# ui_in[1] 0.13345f
C303 pdac.R4c.R1 a_31748_21386# 0.26603f
C304 a_18078_16306# uio_in[5] 0.0631f
C305 a_29508_21386# pdac.R5c.R2 0.2193f
C306 pdac.R6c.R1 ui_in[6] 0.00982f
C307 ndac.R4b.R1 ndac.R6c.R1 0.02498f
C308 ui_in[5] pdac.R5b.R2 0.1677f
C309 a_36788_21386# a_37348_21386# 0.10745f
C310 m5_33808_12580# m5_32128_11860# 0.03053f
C311 ui_in[7] a_25588_21386# 0.06026f
C312 uio_in[7] pdac.OUT 0.12091f
C313 a_25028_21386# uio_in[0] 0.01263f
C314 ndac.R3b.R2 ndac.R5c.R2 0.02498f
C315 uio_in[2] a_22558_16306# 0.13191f
C316 pdac.R5b.R2 pdac.R5c.R2 0.02498f
C317 pdac.R3b.R2 a_31748_21386# 0.15477f
C318 a_33428_21386# a_32868_21386# 0.10745f
C319 pdac.R4b.R1 pdac.R6c.R1 0.02498f
C320 uio_in[6] a_14158_16306# 0.06361f
C321 pdac.R6b.R1 ui_in[6] 0.23281f
C322 ui_in[3] a_32308_21386# 0.06984f
C323 a_36228_21386# pdac.R0b.R1 0.15626f
C324 ui_in[4] a_30628_21386# 0.06378f
C325 ndac.R5b.R2 ndac.R5c.R2 0.02498f
C326 a_37908_21386# a_37348_21386# 0.10745f
C327 a_37348_21386# pdac.R1c.R2 0.16634f
C328 m5_32128_9988# m5_32128_11860# 0.01164f
C329 ndac.R1c.R2 a_26478_16306# 0.16634f
C330 a_35668_21386# ui_in[0] 0.13191f
C331 a_19198_16306# ndac.R4b.R1 0.15626f
C332 uio_in[2] ndac.R4c.R1 0.02837f
C333 pdac.R3c.R2 pdac.R3b.R2 0.02498f
C334 a_33988_21386# pdac.R2c.R1 0.26566f
C335 a_28388_21386# a_28948_21386# 0.10745f
C336 ui_in[2] a_31748_21386# 0.06026f
C337 ndac.R1c.R2 uio_in[0] 0.34488f
C338 a_29508_21386# pdac.R4b.R1 0.15626f
C339 uio_in[7] a_14718_16306# 0.06026f
C340 ndac.R6c.R1 uio_in[5] 0.30056f
C341 a_19198_16306# ndac.R4c.R1 0.01159f
C342 ndac.R5b.R2 a_17518_16306# 0.15477f
C343 a_22558_16306# ndac.R3c.R2 0.2645f
C344 uio_in[6] ndac.R6b.R1 0.23248f
C345 a_18078_16306# uio_in[4] 0.13191f
C346 pdac.OUT ui_in[6] 0.05112f
C347 a_27038_16306# a_26478_16306# 0.10745f
C348 ndac.R0b.R1 ndac.R2c.R1 0.02498f
C349 a_35668_21386# ui_in[1] 0.06026f
C350 ui_in[4] ui_in[5] 0.7103f
C351 ndac.R0d.R1 ndac.R0b.R1 0.02498f
C352 pdac.R3c.R2 ui_in[2] 0.29629f
C353 ndac.R1c.R2 a_25358_16306# 0.21701f
C354 VDPWR comparator.diff 1.88367f
C355 a_27268_21386# a_27828_21386# 0.10745f
C356 uio_in[2] uio_in[5] 0.1593f
C357 ui_in[7] uio_in[0] 0.15129f
C358 a_16958_16306# ndac.R6c.R1 0.22044f
C359 comparator.R1 vbias.Vbias 0.01373f
C360 a_21998_16306# ndac.R2b.R1 0.15626f
C361 a_27038_16306# uio_in[0] 0.02658f
C362 pdac.R5c.R2 a_30628_21386# 0.16634f
C363 ndac.R1c.R2 ndac.R1b.R2 0.02498f
C364 ndac.R6c.R1 a_15838_16306# 0.01159f
C365 pdac.R0d.R1 a_37348_21386# 0.15626f
C366 ndac.R4b.R1 uio_in[4] 0.23472f
C367 ui_in[4] pdac.R5c.R2 0.29629f
C368 pdac.OUT uio_in[1] 0.08499f
C369 ndac.R7c.R2 uio_in[5] 0.0165f
C370 a_20318_16306# ndac.R4c.R1 0.22044f
C371 m5_36256_12820# m5_35056_12388# 0.08108f
C372 comparator.R2 vbias.Vbias 0.18692f
C373 m5_33808_9988# m5_32128_9988# 0.03125f
C374 uio_in[6] ndac.OUT 0.05377f
C375 pdac.R7c.R2 a_27268_21386# 0.16634f
C376 a_27038_16306# a_27598_16306# 0.10745f
C377 a_37348_21386# ui_in[0] 0.06361f
C378 ndac.R4c.R1 uio_in[4] 0.01238f
C379 a_26148_21386# ui_in[6] 0.48535f
C380 a_16958_16306# uio_in[5] 0.48659f
C381 ui_in[2] ui_in[1] 0.26884f
C382 a_23118_16306# ndac.R2c.R1 0.26566f
C383 uio_in[5] a_15838_16306# 0.06026f
C384 ndac.OUT vbias.Vbias 0.28142f
C385 a_30068_21386# a_29508_21386# 0.10745f
C386 a_24238_16306# ndac.R2c.R1 0.26603f
C387 ndac.R6c.R1 uio_in[4] 0.0165f
C388 uio_in[2] ndac.R3c.R2 0.29629f
C389 ndac.R7c.R2 a_15838_16306# 0.2645f
C390 a_25028_21386# a_24468_21386# 0.10745f
C391 ui_in[5] pdac.R5c.R2 0.0068f
C392 a_25028_21386# pdac.R7b.R2 0.15477f
C393 pdac.R7c.R2 pdac.R7b.R2 0.02498f
C394 uio_in[1] ndac.R2c.R1 0.29975f
C395 ndac.R1c.R2 a_24798_16306# 0.26426f
C396 a_27828_21386# pdac.R6c.R1 0.22044f
C397 clk rst_n 0.007f
C398 m5_3520_5044# m5_24400_8500# 0.06264f
C399 uio_in[2] uio_in[4] 0.16076f
C400 uio_in[5] uio_in[4] 3.11538f
C401 ui_in[4] pdac.R4b.R1 0.23351f
C402 ndac.R2b.R1 ndac.R2c.R1 0.02498f
C403 ui_in[5] ui_in[6] 0.92827f
C404 a_19198_16306# uio_in[4] 0.13852f
C405 a_31188_21386# a_31748_21386# 0.10745f
C406 ndac.R6b.R1 a_15278_16306# 0.15626f
C407 uio_in[7] ndac.R7b.R2 0.1677f
C408 pdac.R4c.R1 a_32308_21386# 0.16783f
C409 uio_in[7] uio_in[1] 0.15872f
C410 a_37908_21386# a_38468_21386# 0.10745f
C411 a_23678_16306# ndac.R1b.R2 0.15477f
C412 uio_in[2] uio_in[0] 0.16574f
C413 comparator.R1 VDPWR 1.92689f
C414 uio_in[5] uio_in[0] 0.16273f
C415 ui_in[3] pdac.R4c.R1 0.30476f
C416 uio_in[6] ndac.R6c.R1 0.00745f
C417 ndac.R1c.R2 a_25918_16306# 0.2645f
C418 m5_36352_9988# m5_35104_9892# 0.08168f
C419 uio_in[3] ndac.R4c.R1 0.29481f
C420 pdac.R5b.R2 a_27828_21386# 0.15477f
C421 a_21438_16306# ndac.R4c.R1 0.16783f
C422 ndac.R4c.R1 a_20878_16306# 0.26603f
C423 a_34548_21386# pdac.R2c.R1 0.22044f
C424 a_32868_21386# ui_in[2] 0.48535f
C425 ui_in[7] a_24468_21386# 0.57196f
C426 ui_in[7] pdac.R7b.R2 0.1677f
C427 ui_in[3] pdac.R3b.R2 0.1677f
C428 a_30068_21386# a_30628_21386# 0.10745f
C429 ndac.OUT VDPWR 0.22907f
C430 a_18638_16306# a_18078_16306# 0.10745f
C431 a_30068_21386# ui_in[4] 0.13769f
C432 uio_in[2] uio_in[6] 0.15885f
C433 pdac.R5b.R2 pdac.R7c.R2 0.02498f
C434 uio_in[6] uio_in[5] 3.21735f
C435 ena VGND 0.05967f
C436 clk VGND 0.04104f
C437 rst_n VGND 0.04104f
C438 uio_in[0] VGND 7.88031f
C439 uio_in[1] VGND 4.97484f
C440 uio_in[2] VGND 4.59684f
C441 uio_in[3] VGND 4.39849f
C442 uio_in[4] VGND 4.87533f
C443 uio_in[5] VGND 5.15682f
C444 uio_in[6] VGND 5.24434f
C445 uio_in[7] VGND 9.22207f
C446 ui_in[0] VGND 4.34439f
C447 ui_in[1] VGND 3.51829f
C448 ui_in[2] VGND 3.63455f
C449 ui_in[3] VGND 3.74544f
C450 ui_in[4] VGND 3.87575f
C451 ui_in[5] VGND 3.95876f
C452 ui_in[6] VGND 4.0188f
C453 ui_in[7] VGND 5.17364f
C454 uo_out[7] VGND 4.80301f
C455 VDPWR VGND 30.51573f
C456 m5_24400_8500# VGND 0.91015f ; **FLOATING
C457 m5_37456_9556# VGND 0.72739f ; **FLOATING
C458 m5_36352_9988# VGND 0.41504f ; **FLOATING
C459 m5_35104_9892# VGND 0.47197f ; **FLOATING
C460 m5_33808_9988# VGND 0.6999f ; **FLOATING
C461 m5_32128_9988# VGND 0.47875f ; **FLOATING
C462 m5_30928_9556# VGND 0.55941f ; **FLOATING
C463 m5_26080_10468# VGND 0.4166f ; **FLOATING
C464 m5_30016_10564# VGND 0.50666f ; **FLOATING
C465 m5_36256_12820# VGND 0.80793f ; **FLOATING
C466 m5_35056_12388# VGND 0.45413f ; **FLOATING
C467 m5_33808_12580# VGND 0.50147f ; **FLOATING
C468 m5_32128_11860# VGND 0.66264f ; **FLOATING
C469 m5_31792_12388# VGND 0.21424f ; **FLOATING
C470 m5_31264_12388# VGND 0.13164f ; **FLOATING
C471 m5_30160_12388# VGND 0.5539f ; **FLOATING
C472 m5_31216_13780# VGND 0.0821f ; **FLOATING
C473 m5_14800_14164# VGND 0.07422f ; **FLOATING
C474 m5_15472_14500# VGND 0.08323f ; **FLOATING
C475 m5_3520_5044# VGND 41.8374f ; **FLOATING
C476 ndac.R0d.R1 VGND 4.27155f
C477 ndac.R0b.R1 VGND 4.12281f
C478 ndac.R1c.R2 VGND 6.36004f
C479 ndac.R1b.R2 VGND 4.10867f
C480 ndac.R2c.R1 VGND 6.36394f
C481 ndac.R2b.R1 VGND 4.12134f
C482 ndac.R3c.R2 VGND 6.33395f
C483 ndac.R3b.R2 VGND 4.10867f
C484 ndac.R4c.R1 VGND 6.36207f
C485 ndac.R4b.R1 VGND 4.12135f
C486 ndac.R5c.R2 VGND 6.33395f
C487 ndac.R5b.R2 VGND 4.10867f
C488 ndac.R6c.R1 VGND 6.36526f
C489 ndac.R6b.R1 VGND 4.12302f
C490 ndac.R7c.R2 VGND 6.33395f
C491 ndac.R7b.R2 VGND 4.16737f
C492 pdac.R0d.R1 VGND 4.24917f
C493 pdac.R0b.R1 VGND 4.10575f
C494 pdac.R1c.R2 VGND 6.36977f
C495 pdac.R1b.R2 VGND 4.11554f
C496 pdac.R2c.R1 VGND 6.32574f
C497 pdac.R2b.R1 VGND 4.10581f
C498 pdac.R3c.R2 VGND 6.34535f
C499 pdac.R3b.R2 VGND 4.11554f
C500 pdac.R4c.R1 VGND 6.32815f
C501 pdac.R4b.R1 VGND 4.10776f
C502 pdac.R5c.R2 VGND 6.39167f
C503 pdac.R5b.R2 VGND 4.12811f
C504 pdac.R6c.R1 VGND 6.34355f
C505 pdac.R6b.R1 VGND 4.10931f
C506 pdac.R7c.R2 VGND 6.37608f
C507 pdac.R7b.R2 VGND 4.18331f
C508 comparator.R2 VGND 7.48136f
C509 pdac.OUT VGND 3.29149f
C510 VGND.t7 VGND 3.80347f
C511 VGND.t63 VGND 3.81963f
C512 VGND.t40 VGND 3.99522f
C513 VGND.t26 VGND 2.07623f
C514 VGND.t68 VGND 2.07048f
C515 VGND.t27 VGND 2.07623f
C516 VGND.t18 VGND 2.67813f
C517 VGND.t36 VGND 2.07466f
C518 VGND.t65 VGND 2.08431f
C519 VGND.t37 VGND 2.07466f
.ends
