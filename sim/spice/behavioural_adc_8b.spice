* Behavioural ADC for simulation TB driving.
* Takes in a voltage (vin) in the range [0,1.2] and outputs
* 8-bit digital 1.2V logic levels. Also applies finite
* edge rates using RC filtering.
.subckt behavioural_adc_8b vin d7 d6 d5 d4 d3 d2 d1 d0
.param VREF=1.2
.param ROUT=100
.param COUT=5p
* Clamp normalized input to 0 <= x < 1.
.func adc_x(v) { min(max(v/VREF, 0), 0.999999) }
* Return bit 0 of a non-negative integer-valued x.
* Equivalent to x modulo 2, without requiring mod().
.func bit(x) { floor(x) - 2*floor(x/2) }
* 8-bit ideal quantizer.
* d0 = LSB, d7 = MSB.
B0 q0 0 V = VREF*bit(adc_x(V(vin))*256)
B1 q1 0 V = VREF*bit(adc_x(V(vin))*128)
B2 q2 0 V = VREF*bit(adc_x(V(vin))*64)
B3 q3 0 V = VREF*bit(adc_x(V(vin))*32)
B4 q4 0 V = VREF*bit(adc_x(V(vin))*16)
B5 q5 0 V = VREF*bit(adc_x(V(vin))*8)
B6 q6 0 V = VREF*bit(adc_x(V(vin))*4)
B7 q7 0 V = VREF*bit(adc_x(V(vin))*2)
* Finite output impedance / edge rate
R0 q0 d0 {ROUT}
R1 q1 d1 {ROUT}
R2 q2 d2 {ROUT}
R3 q3 d3 {ROUT}
R4 q4 d4 {ROUT}
R5 q5 d5 {ROUT}
R6 q6 d6 {ROUT}
R7 q7 d7 {ROUT}
C0 d0 0 {COUT}
C1 d1 0 {COUT}
C2 d2 0 {COUT}
C3 d3 0 {COUT}
C4 d4 0 {COUT}
C5 d5 0 {COUT}
C6 d6 0 {COUT}
C7 d7 0 {COUT}
.ends ideal_adc8
