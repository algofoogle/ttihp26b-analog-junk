Example r2r_dac TB: Convert analog sine to digital inputs, then back to digital via ideal & PEX DAC instances

.lib cornerRES.lib res_typ $ NOTE: Can use res_stat for statistical (Monte-Carlo-Like) modeling instead.
.lib cornerMOSlv.lib mos_tt
.include "$PDK_ROOT/$PDK/libs.ref/sg13g2_stdcell/spice/sg13g2_stdcell.spice"

.include "behavioural_adc_8b.spice"
.include "../../magic/tt_um_algofoogle_analog_junk.sim.spice"
.include "../../xschem/simulation/r2r_dac.spice"

* Positive and negative inputs to the comparator, as their analog sources, range [0,1.2]V:
Vp vinpa GND SIN(0.6 0.6 3Meg) $ 3MHz
Vn vinna GND PWL(0 0   100u 1.2   200u 0)

Vvdpwr VDPWR GND 1.2

Rena ena VDPWR 1k

Xadcp vinpa  p7 p6 p5 p4 p3 p2 p1 p0  behavioural_adc_8b
Xadcn vinna  n7 n6 n5 n4 n3 n2 n1 n0  behavioural_adc_8b

* Convert pdac bits to actual TT-mux-driven inputs:
Xui_in0 ui_in[0] p0 ena VDPWR GND sg13g2_and2_2
Xui_in1 ui_in[1] p1 ena VDPWR GND sg13g2_and2_2
Xui_in2 ui_in[2] p2 ena VDPWR GND sg13g2_and2_2
Xui_in3 ui_in[3] p3 ena VDPWR GND sg13g2_and2_2
Xui_in4 ui_in[4] p4 ena VDPWR GND sg13g2_and2_2
Xui_in5 ui_in[5] p5 ena VDPWR GND sg13g2_and2_2
Xui_in6 ui_in[6] p6 ena VDPWR GND sg13g2_and2_2
Xui_in7 ui_in[7] p7 ena VDPWR GND sg13g2_and2_2
* Convert ndac bits to actual TT-mux-driven inputs:
Xuio_in0 uio_in[0] n0 ena VDPWR GND sg13g2_and2_2
Xuio_in1 uio_in[1] n1 ena VDPWR GND sg13g2_and2_2
Xuio_in2 uio_in[2] n2 ena VDPWR GND sg13g2_and2_2
Xuio_in3 uio_in[3] n3 ena VDPWR GND sg13g2_and2_2
Xuio_in4 uio_in[4] n4 ena VDPWR GND sg13g2_and2_2
Xuio_in5 uio_in[5] n5 ena VDPWR GND sg13g2_and2_2
Xuio_in6 uio_in[6] n6 ena VDPWR GND sg13g2_and2_2
Xuio_in7 uio_in[7] n7 ena VDPWR GND sg13g2_and2_2

XDUT
+   clk ena rst_n
+     ui_in[0]   ui_in[1]   ui_in[2]   ui_in[3]   ui_in[4]   ui_in[5]   ui_in[6]   ui_in[7]
+    uio_in[0]  uio_in[1]  uio_in[2]  uio_in[3]  uio_in[4]  uio_in[5]  uio_in[6]  uio_in[7]
+    uio_oe[0]  uio_oe[1]  uio_oe[2]  uio_oe[3]  uio_oe[4]  uio_oe[5]  uio_oe[6]  uio_oe[7]
+   uio_out[0] uio_out[1] uio_out[2] uio_out[3] uio_out[4] uio_out[5] uio_out[6] uio_out[7]
+    uo_out[0]  uo_out[1]  uo_out[2]  uo_out[3]  uo_out[4]  uo_out[5]  uo_out[6]  comp_out
+   VDPWR GND
+ tt_um_algofoogle_analog_junk_pex

Xdacp p7 p6 p5 p4 p3 p2 p1 p0 vdacp GND r2r_dac
Xdacn n7 n6 n5 n4 n3 n2 n1 n0 vdacn GND r2r_dac

.control
tran 200p 200u
save
+ vinpa vdacp
+ p0 p1 p2 p3 p4 p5 p6 p7
+ vinna vdacn
+ n0 n1 n2 n3 n4 n5 n6 n7
+ comp_out
+ i(vvdpwr)
write tb_top.raw
+ vinpa vdacp
+ p0 p1 p2 p3 p4 p5 p6 p7
+ vinna vdacn
+ n0 n1 n2 n3 n4 n5 n6 n7
+ comp_out
+ i(vvdpwr)
* plot vinpa vinna comp_out max(0,min(1,1000*(vinpa-vinna))) vdacp vdacn
.endc
